ADE simulation setup
Test Project_top_tb_1: Project/top_tb/schematic, simulator spectre
  Models: /cadappl_sde/iclibs/AT_4000TG/AT_4000TG/monte.scs[typical]
  Variables: iw = 4000; lw = 2000; csw = 2000; vc = 1; VCM = 10.2; vb = 1
  Temperature: 27
  Analysis noise: start=0.01 stop=1000 p=/vop n=/von iprobe=/V1
  Output IDC("/I8/VDD") (unticked)
  Output Current = i("/I8/VDD" ?result "dc") (unticked)
  Output CC = i("/I8/M11/d" ?result "dc") (unticked)
  Output Gainp = dB20(((VF("/vop") - VF("/von")) / (VF("/vip") - VF("/vin")))) (unticked)
  Output VCM = ((VDC("/vop") + VDC("/vop")) / 2) (unticked)
  Output abs((VF("/I8/vfbp") / VF("/I8/vfbn"))) (unticked)
  Output phase((VF("/I8/vfbp") / VF("/vop"))) (unticked)
  Output gain = value(dB20(((VF("/vop") - VF("/von")) / (VF("/vip") - VF("/vin")))) 1) (unticked)
  Output bw = bandwidth(dB20(((VF("/vop") - VF("/von")) / (VF("/vip") - VF("/vin")))) 3 "low") (unticked)
  Output input noise; V / sqrt(Hz) = getData("in" ?result "noise") (unticked)
  Output sqrt(integ((getData("in" ?result "noise")**2) 0.05 100))
  Signals: /I8/VDD (terminal), /I8/M11/d (terminal), /vop, /von, /vip, /vin, /I8/vfbp, /I8/vfbn
Run mode: Single Run, Sweeps and Corners
Setup values for test Project_top_tb_1: iw = 4000 8000 16000
