ADE simulation setup
Test Project_top_tb_1: Project/top_tb/schematic, simulator spectre
  Models: /cadappl_sde/iclibs/AT_4000TG/AT_4000TG/monte.scs[typical]
  Variables: vb = 1; vc = 1; VCM = 22.5:0.1:23.5; CurrentW = 1k; cw = 1k; cl = 300; CurrentL = 300; InputW = 25k; LoadW = 3.2k; LevelW = 12k; PW = 8k; InputL = 180; LoadL = 620; LevelL = 200; PL = 200
  Temperature: 27
  Analysis dc: (saves the operating point)
  Analysis ac: start=0.01 stop=10k
  Analysis noise: start=0.01 stop=1000 p=/vop n=/von iprobe=/V1
  Output Gainp = dB20(((VF("/vop") - VF("/von")) / (VF("/vip") - VF("/vin")))) (unticked)
  Output VCM = ((VDC("/vop") + VDC("/vop")) / 2)
  Output gain = value(dB20(((VF("/vop") - VF("/von")) / (VF("/vip") - VF("/vin")))) 1)
  Output bw = bandwidth(dB20(((VF("/vop") - VF("/von")) / (VF("/vip") - VF("/vin")))) 3 "low")
  Output NoiseCruve = getData("in" ?result "noise") (unticked)
  Output Noise = sqrt(integ((getData("in" ?result "noise")**2) 0.05 100))
  Signals: /vop, /von, /vip, /vin
Run mode: Single Run, Sweeps and Corners
Setup values for test Project_top_tb_1: VCM = 10.2; csw = 2000; iw = 4000 8000 16000; lw = 2000
