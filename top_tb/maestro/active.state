ADE simulation setup
Test Project_top_tb_1: Project/top_tb/schematic, simulator spectre
  Models: /cadappl_sde/iclibs/AT_4000TG/AT_4000TG/monte.scs[typical]
  Variables: VCM = 10; vb = 15
  Temperature: 27
  Analysis ac: start=0.01 stop=1k
  Output Gain = dB20(((VF("/vop") - VF("/von")) / (VF("/vip") - VF("/vin"))))
  Output v /I0/net2; dc (V) = v("/I0/net2" ?result "dc") (unticked)
Run mode: Single Run, Sweeps and Corners
Setup values for test Project_top_tb_1: vb = 1; VCM = 10.2; vc = 1; csw = 2000; iw = 4000 8000 16000; lw = 2000
