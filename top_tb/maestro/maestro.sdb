ADE simulation setup
Run mode: Single Run, Sweeps and Corners
Tests:
  Project_top_tb_1: Project/top_tb/schematic, simulator spectre
    Variables: vb = 1; vc = 1; VCM = 22.5:0.1:23.5; CurrentW = 1k; cw = 1k; cl = 300; CurrentL = 300; InputW = 25k; LoadW = 3.2k; LevelW = 12k; PW = 8k; InputL = 180; LoadL = 620; LevelL = 200; PL = 200
    Outputs: Gainp; gain; bw
Specs:
  Project_top_tb_1 / gain: > 20
  Project_top_tb_1 / bw: > 100
  Project_top_tb_1 / Noise: < 44.5u
