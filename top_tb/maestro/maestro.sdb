ADE simulation setup
Run mode: Single Run, Sweeps and Corners
Tests:
  Project_top_tb_1: Project/top_tb/schematic, simulator spectre
    Variables: vb = 15; VCM = 10
    Outputs: Gain
