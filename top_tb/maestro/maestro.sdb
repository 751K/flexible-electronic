ADE simulation setup
Run mode: Single Run, Sweeps and Corners
Tests:
  Project_top_tb_1: Project/top_tb/schematic, simulator spectre
    Variables: vb = 1; VCM = 10.2; vc = 1; csw = 2000; iw = 4000 8000 16000; lw = 2000
    Outputs: CC; Gainp; abs((VF("/I8/vfbp") / VF("/I8/vfbn"))); phase((VF("/I8/vfbp") / VF("/vop"))); gain; bw
